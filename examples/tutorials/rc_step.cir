rc low-pass
V1 in 0 PULSE(0 1 0 1n 1n 1 0)
R1 in out 1k
C1 out 0 1u
