values with suffixes
V1 in 0 5
R1 in out 4.7k
R2 out 0 4700
.op
