voltage divider of 1 kohm and 3 kohm on 10 V
V1 in 0 DC 10
R1 in out 1k
R2 out 0 3k
.op
.end
